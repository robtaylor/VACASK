`include "constants.vams"
`include "disciplines.vams"

module inductor(A,B);
	inout A, B;
	electrical A, B;

	branch (A,B) br;

	(*desc= "Inductance", type="instance", units = "H"*) parameter real l = 1e-6 from [0:inf];
	(*desc= "Flux", units ="Vs" *) real flux;

	real Phi;

	analog begin
                Phi = l * I(br);
                V(br) <+ ddt(Phi);
                flux = Phi;
                // $display("%.12e", I(br));<
	end
endmodule
